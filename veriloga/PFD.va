`include "constants.vams"
`include "disciplines.vams"

module PFD(REF,FB,UP,DN);

parameter real VDD = 1.2;
parameter real thresh = 0.6;
parameter real trise = 10p, tfall = 10p, td = 0;

input REF,FB;
output UP,DN;

electrical REF,FB,UP,DN;

real UP_i, DN_i;

analog begin

@(cross(V(REF)-thresh,1))
if(DN_i < thresh)
UP_i = VDD;
else begin
UP_i = 0;
DN_i = 0;
end

@(cross(V(FB)-thresh,1))
if(UP_i < thresh)
DN_i = VDD;
else begin
UP_i = 0;
DN_i = 0;
end

V(UP) <+ transition(UP_i,td,trise,tfall);
V(DN) <+ transition(DN_i,td,trise,tfall);

end
endmodule
