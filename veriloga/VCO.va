`include "constants.vams"
`include "disciplines.vams"

module VCO(VCTRL,VOUT);

parameter real VHIGH = 1.2;
parameter real Vmin=0;
parameter real Vmax=1 from (Vmin:inf);
parameter real Fmin=0.8G from (0:inf);
parameter real Fmax=3.04G from (Fmin:inf);

parameter real trise=10p, tfall=10p, td=0;

input VCTRL;
output VOUT;

voltage VCTRL,VOUT;

real freq, phase, sine, VOUT_i;

analog begin

freq =((V(VCTRL) - Vmin)*(Fmax - Fmin) / (Vmax - Vmin)) + Fmin;

if (freq > Fmax) freq = Fmax;
if (freq < Fmin) freq = Fmin;

phase = 2*`M_PI*idtmod(freq, 0.0, 1.0, -0.5);

sine = sin(phase);

@(cross(sine,0));

if (sine > 0)
VOUT_i = VHIGH;
else
VOUT_i = 0;

V(VOUT) <+ transition(VOUT_i,td,trise,tfall);

$bound_step(0.1/freq);

end
endmodule
